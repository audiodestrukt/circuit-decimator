* Single-ended, plate-loaded output transformer: line source -> 12AU7 ->
* 4:1 gapped-steel output transformer -> 10k line load. The plate current
* flows through the primary, so the core carries a DC bias: asymmetric B-H
* excursions, even harmonics, early low-frequency saturation. The air gap lg
* sets how much DC bias the core sees (less gap = more bias, more colour).
*
* Power-on: B+ ramps up from 0 over tramp (uic) so the core magnetises itself;
* the tone starts at tsig once settled. A slow ramp (1 s) keeps the plate
* current monotonic, so the core lands on its initial magnetization curve (as
* the engine's initDC assumes); a fast one overshoots and leaves it on a
* different hysteresis branch.

* ---- output transformer -----------------------------------------------------
.param n=0.25 rprim=800 llp=10m rsec=40 lls=0.6m csec=200p rload=10k
* ---- core: gapped silicon steel -----------------------------------------------
.param np=4000 ac=6e-4 le=0.1 lg=1e-4
.param ms=1.3e6 ja=100 alpha=1e-4 kpin=20 cr=0.3
.param mu0=1.25663706e-6
* ---- 12AU7 stage ----------------------------------------------------------------
.param bplus=250 rsrc=600 rgk=1meg rk=820 ck=100u
.param mu=21.5 ex=1.3 kg1=1180 kp=84 kvb=300 kgc=4e-4
.param cgk=1.6p cgp=1.5p cpk=0.5p
* ---- drive ------------------------------------------------------------------------
.param amp=1 freq=50 tramp=1 tsig=1.3 cycles=12

.func lang(x) {abs(x) < 1e-4 ? x/3 : cosh(x)/sinh(x) - 1/x}
.func dlang(x) {abs(x) < 1e-4 ? 1/3 - x*x/15 : 1/(x*x) - 1/(sinh(x)*sinh(x))}
.func clampx(x) {min(max(x, -80), 80)}
.func softplus(x) {x > 30 ? x : ln(1 + exp(x))}

Vbp bp 0 PWL(0 0 {tramp} {bplus})
Bvin src 0 V={time < tsig ? 0 : amp * sin(2*3.14159265358979*freq*(time - tsig)) * min(1, (time - tsig)*freq/4)}
Rs1 src grid {rsrc}
Rgk grid 0 {rgk}
Rk cath 0 {rk}
Ck cath 0 {ck}
Cgk grid cath {cgk}
Cgp grid plate {cgp}
Cpk plate cath {cpk}
Be1 e1 0 V={max(v(plate,cath), 0) / kp * softplus(kp * (1/mu + v(grid,cath) / sqrt(kvb + max(v(plate,cath),0)**2)))}
Bip plate cath I={v(e1) > 0 ? 2 * pwr(v(e1), ex) / kg1 : 0}
Big grid cath I={kgc * pwr(0.05 * softplus(v(grid,cath) / 0.05), 1.5)}

* ---- primary: plate -- DCR -- leakage -- m; core between m and B+ ---------------
Rpr plate pa {rprim}
Llp pa m {llp}
Glam 0 lam cur={v(m,bp)}
Clam lam 0 1
Rlam lam 0 1e15
Gmm 0 mm cur={v(dmdb) / ms * v(m,bp) / (np*ac)}
Cmm mm 0 1
Rmm mm 0 1e15
Bbb bb 0 V={v(lam) / (np*ac)}
Bhh hh 0 V={v(bb)/mu0 - ms*v(mm)}
Bhe he 0 V={v(hh) + alpha*ms*v(mm)}
Bman man 0 V={ms * lang(clampx(v(he)/ja))}
Bdman dman 0 V={ms/ja * dlang(clampx(v(he)/ja))}
Bdel del 0 V={v(m,bp) >= 0 ? 1 : -1}
Bdmdh dmdh 0 V={((1-cr) * (((v(man) - ms*v(mm)) * v(del) > 0) ? 1 : 0) * (v(man) - ms*v(mm)) / ((1-cr)*v(del)*kpin - alpha*(v(man) - ms*v(mm))) + cr*v(dman)) / (1 - cr*alpha*v(dman))}
Bdmdb dmdb 0 V={v(dmdh) / (mu0 * (1 + v(dmdh)))}
* ampere-turns drive the core path and the gap
Bim m bp I={(v(hh)*le + v(bb)/mu0*lg) / np}

* ---- ideal n:1 to the secondary -----------------------------------------------------
Exf sp xs m bp {n}
Vxf xs 0 0
Fxf bp m Vxf {n}
Lls sp sa {lls}
Rsc sa out {rsec}
Csc out 0 {csec}
Rld out 0 {rload}

.options reltol=1e-4 abstol=1e-12 vntol=1e-7
.control
set wr_singlescale
set wr_vecnames
tran 2e-5 0.49 0 2e-5 uic
wrdata se.dat v(out) v(bb) v(hh) v(plate)
quit
.endc
.end
